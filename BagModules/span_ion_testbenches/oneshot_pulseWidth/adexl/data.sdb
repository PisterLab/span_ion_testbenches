ADE simulation setup
Run mode: Monte Carlo Sampling
Tests:
  span_ion_testbenches:oneshot_pulseWidth:1: span_ion_testbenches/oneshot_pulseWidth/schematic, simulator spectre
Global variables:
  CL = 0
  VDD = 1.8
  TD_POWER = 1n
  TSTOP = 200u
  b0 = 0
  b1 = 0
  CAP_VAL = 0
Monte Carlo Sampling options: mcmethod=all, mcnumpoints=200
